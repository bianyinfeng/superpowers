* RC step response
V1 in 0 5
R1 in out 1k
C1 out 0 1u
.tran 0.0001 0.001
.end
