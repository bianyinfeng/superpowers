* diode DC example
V1 in 0 1
R1 in out 1k
D1 out 0 DMOD
.model DMOD D IS=1e-12 N=1
.op
.end
